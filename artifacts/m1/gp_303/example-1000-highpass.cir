* Developed passive network; wires contracted
* Vout = n4; logical fixture source/load preserved
Vsource n1 0 AC 1
Rsource n1 n2 1000
Rload n4 0 1000
L1 n2 n3 0.00063245553203367599
C2 n3 n4 2.0000000000000004e-08
.ac dec 100 100 1000000
.end
